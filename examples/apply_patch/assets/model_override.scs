simulator lang=spectre
parameters gain_trim=1.05
