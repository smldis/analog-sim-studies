simulator lang=spectre
include "/seed/netlists/rc_filter.scs"

X1 in out rc_filter
tran tran stop=10u
save V(out)
