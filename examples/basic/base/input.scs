simulator lang=spectre
include "/seed/netlists/rc_filter.scs"

*** reusable subcircuit definitions
.SUBCKT rc_filter in out
R1 in out 1k
C1 out 0 1p
.ENDS rc_filter

X1 in out rc_filter
tran tran stop=10u
save V(out)
